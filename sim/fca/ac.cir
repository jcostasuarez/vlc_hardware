* FCA channel A - native TI OPA2675 macro-model (converted to ngspice)
* Model: sim/models/opa2675.lib  (INp INm OUT VCC VEE A0 GND)
* Board: R11=402 / R9=133 (G=4.02), R7=49.9, R4=R5=5.1k, C4=C6=C8=C9=0.1u, VCC=5V.
.include ../models/opa2675.lib
.param VCC=5
Vcc  vcc 0 {VCC}
Vee  vee 0 {-VCC}
Vin  src 0 ac 1
Rs   src in 50
C4   in npi 0.1u
R7   npi npi2 49.9
C6   npi2 0 0.1u
R4   vcc npi2 5.1k
R5   npi2 0 5.1k
XU   npi2 nni outa vcc vee 0 0 OPA2675
R11  nni outa 402
R9   nni c8 133
C8   c8 0 0.1u
C9   outa o1 0.1u
R13  o1 out 1
Rl   out 0 50
.ac dec 100 10k 5G
.end
