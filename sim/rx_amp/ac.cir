* RX amplifier - AC (BGA616)
* NOTE: the vendor BGA616 model is a datasheet/PSpice model that ngspice
* cannot run.  The amplifier is modelled as a 50-ohm, 20 dB gain block so that
* the board coupling/bias network can be simulated; replace XAMP with the
* vendor model when an ngspice-compatible one is available.
* Board values: C1=C2=0.1u, L1=L2=10uH, R1=15, L3 ferrite.
.param VCC=5
Vcc  vcc 0 {VCC}
Vin  src 0 dc 0 ac 1
Rs   src in 50
C1   in amp_in 0.1u
* 50-ohm gain block (BGA616 placeholder, G = 10 -> 20 dB)
Ri   amp_in 0 50
E1   a 0 amp_in 0 10
Ro   a amp_out 50
* bias feed
L1   n3 vb 10u
R1   n3 vb 15
L3   vcc n3 0.22u
C3   n3 0 0.1u
L2   vb amp_out 10u
C2   amp_out out 0.1u
Rl   out 0 50
.ac dec 100 100k 10G
.end
