* RX amplifier - AC (BGA616 buffer / gain block)
* Board values from Receiver/AMP/rx_amp.kicad_sch:
*   C1=C2=0.1u coupling, L1=L2=10uH bias feed, R1=15, L3 ferrite, VCC=5V.
* The BGA616 has no public SPICE netlist; sim/models/bga616.lib is a
* datasheet-based 50-ohm, 19 dB gain block.
.include ../models/bga616.lib
.param VCC=5
Vcc  vcc 0 {VCC}
Vin  src 0 dc 0 ac 1
Rs   src in 50
C1   in amp_in 0.1u
XB   amp_in amp_out 0 BGA616
L1   n3 n1b 10u
R1   n3 n1a 15
L3   vcc n3 0.22u
C3   n3 0 0.1u
L2   n1b amp_out 10u
C2   amp_out out 0.1u
Rl   out 0 50
.ac dec 100 100k 10G
.end
