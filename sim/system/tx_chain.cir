* TX chain: Pitaya DAC -> pre-emphasis -> discrete amp -> LED board.
* Interfaces are 50 ohm SMA.  LED current sensed by Vsense.
.include ../models/bfr740l3rh.lib
.include ../models/preemphasis.sub
.include ../models/tx_amp.sub
.param VCC=3.3
Vsrc src 0 dc 0 ac 1
Rs   src in 50
XPRE in p1 0 PREEMPHASIS
XAMP p1 n1 vcc 0 TXAMP
L1   vbias n1 206n
Vbias vbias 0 {VCC} ac 0
Vsense n1 a 0
R8   a b 1.35
L3   b c 0.99n
R9   c d 0.54
C4   c d 130n
R10  d 0 0.39
C2   n1 mon 0.1u
Rmon mon 0 50
.ac dec 200 10k 1G
.end
