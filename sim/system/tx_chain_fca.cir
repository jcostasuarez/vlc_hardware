* TX chain variant: Pitaya DAC -> pre-emphasis -> FCA (OPA2675) -> LED board.
.include ../models/opa2675.lib
.include ../models/preemphasis.sub
.include ../models/fca.sub
.param VCC=5
Vsrc src 0 dc 0 ac 1
Rs   src in 50
XPRE in p1 0 PREEMPHASIS
XF   p1 n1 vcc {-VCC} 0 FCA
L1   vbias n1 206n
Vbias vbias 0 {VCC} ac 0
Vsense n1 a 0
R8   a b 1.35
L3   b c 0.99n
R9   c d 0.54
C4   c d 130n
R10  d 0 0.39
.ac dec 200 10k 1G
.end
