* TX chain variant: Pitaya DAC -> pre-emphasis -> FCA (OPA2675) -> BIAS-TEE -> LED.
.include ../models/opa2675.lib
.include ../models/preemphasis.sub
.include ../models/fca.sub
.include ../models/bias_tee.sub
.include ../models/led_equiv.sub
.param VCC=5
Vsrc src 0 dc 0 ac 1
Rs   src in 50
XPRE in p1 0 PREEMPHASIS
XF   p1 n1 vcc {-VCC} 0 FCA
Vbias vbias 0 {VCC} ac 0
Rdcn1 n1 0 1e9
XBT  n1 vbias nled 0 BIAS_TEE
Vsense nled a 0
Cdcl a a2 1u
Rdc  a 0 1e9
XLED a2 0 LED_EQ
.ac dec 200 10k 1G
.end
