* LMH34400 TIA - noise
.include ../models/opamp_2pole.sub
.include ../models/tia_block.sub
.param VCC=3.3
Vcc  vcc 0 {VCC}
* photodiode drives the TIA input directly (JP1 closed); R1/C1/R2/C2 are the
* alternate AC-coupled input on J1 and do not load the TIA in this model.
Iph  0 in ac 1
Cd   in 0 5p
Rsh  in 0 1e9
XT   in out vcc 0 TIABLK zt=20k fp=240Meg en=2.35n in=2.5p cin=1.5p
Ro   out o50 49.9
Rl   o50 0 50
.noise v(o50) Iph dec 50 1k 500Meg
.end
