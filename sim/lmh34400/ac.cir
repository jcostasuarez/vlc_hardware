* LMH34400 TIA - native TI macro-model (converted to ngspice)
* Model: sim/models/lmh34400.lib  (IN VDD nEN nIDC_EN GND OUT)
* Integrated transimpedance gain 40 kohm, BW 240 MHz, CPD = 1 pF.
* Board: R4=49.9 output back-termination, VCC = 3.3 V.
.include ../models/lmh34400.lib
.param VCC=3.3
Vdd  vdd 0 {VCC}
Ven  nen 0 0
Valc nidc 0 3.3
Iph  0 in ac 1
Cd   in 0 1p
XU1  in vdd nen nidc 0 out LMH34400
Ro   out o50 49.9
Rl   o50 0 50
.ac dec 100 1k 1G
.end
